//
simulator lang=spectre

global 0 vdd!

include "umc_sim_models_ff.scs"

include "adc_analog_spice_common.scs"
