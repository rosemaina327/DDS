//
simulator lang=spectre

global 0 vdd!
include "/adl/design_kits/UMC/umc-65/UMK65FDKLLC00000OA_B11_DESIGNKIT/umc65ll/../Models/Spectre/l65ll_v181.lib.scs" section=tt_ll_rvt12
include "/adl/design_kits/UMC/umc-65/UMK65FDKLLC00000OA_B11_DESIGNKIT/umc65ll/../Models/Spectre/l65ll_v181.lib.scs" section=tt_ll_hvt12
include "/adl/design_kits/UMC/umc-65/UMK65FDKLLC00000OA_B11_DESIGNKIT/umc65ll/../Models/Spectre/l65ll_v181.lib.scs" section=tt_ll_lvt12
include "/adl/design_kits/UMC/umc-65/UMK65FDKLLC00000OA_B11_DESIGNKIT/umc65ll/../Models/Spectre/l65ll_v181.lib.scs" section=tt_ll_io18
include "/adl/design_kits/UMC/umc-65/UMK65FDKLLC00000OA_B11_DESIGNKIT/umc65ll/../Models/Spectre/l65ll_v181.lib.scs" section=tt_ll_io25od33
include "/adl/design_kits/UMC/umc-65/UMK65FDKLLC00000OA_B11_DESIGNKIT/umc65ll/../Models/Spectre/l65ll_v181.lib.scs" section=tt_ll_io33
include "/adl/design_kits/UMC/umc-65/UMK65FDKLLC00000OA_B11_DESIGNKIT/umc65ll/../Models/Spectre/l65ll_v181.lib.scs" section=tt_ll_nvt12
include "/adl/design_kits/UMC/umc-65/UMK65FDKLLC00000OA_B11_DESIGNKIT/umc65ll/../Models/Spectre/l65ll_v181.lib.scs" section=tt_ll_nvt12_bpw
include "/adl/design_kits/UMC/umc-65/UMK65FDKLLC00000OA_B11_DESIGNKIT/umc65ll/../Models/Spectre/l65ll_v181.lib.scs" section=tt_ll_nvt18
include "/adl/design_kits/UMC/umc-65/UMK65FDKLLC00000OA_B11_DESIGNKIT/umc65ll/../Models/Spectre/l65ll_v181.lib.scs" section=tt_ll_nvt18_bpw
include "/adl/design_kits/UMC/umc-65/UMK65FDKLLC00000OA_B11_DESIGNKIT/umc65ll/../Models/Spectre/l65ll_v181.lib.scs" section=tt_ll_nvt25od33
include "/adl/design_kits/UMC/umc-65/UMK65FDKLLC00000OA_B11_DESIGNKIT/umc65ll/../Models/Spectre/l65ll_v181.lib.scs" section=tt_ll_nvt25od33_bpw
include "/adl/design_kits/UMC/umc-65/UMK65FDKLLC00000OA_B11_DESIGNKIT/umc65ll/../Models/Spectre/l65ll_v181.lib.scs" section=tt_ll_nvt33
include "/adl/design_kits/UMC/umc-65/UMK65FDKLLC00000OA_B11_DESIGNKIT/umc65ll/../Models/Spectre/l65ll_v181.lib.scs" section=tt_ll_nvt33_bpw
include "/adl/design_kits/UMC/umc-65/UMK65FDKLLC00000OA_B11_DESIGNKIT/umc65ll/../Models/Spectre/l65ll_v181.lib.scs" section=tt_ll_bjt
include "/adl/design_kits/UMC/umc-65/UMK65FDKLLC00000OA_B11_DESIGNKIT/umc65ll/../Models/Spectre/l65ll_v181.lib.scs" section=tt_ll_diode
include "/adl/design_kits/UMC/umc-65/UMK65FDKLLC00000OA_B11_DESIGNKIT/umc65ll/../Models/Spectre/l65ll_v181.lib.scs" section=tt_ll_momcaps
include "/adl/design_kits/UMC/umc-65/UMK65FDKLLC00000OA_B11_DESIGNKIT/umc65ll/../Models/Spectre/l65ll_v181.lib.scs" section=tt_ll_ncap12
include "/adl/design_kits/UMC/umc-65/UMK65FDKLLC00000OA_B11_DESIGNKIT/umc65ll/../Models/Spectre/l65ll_v181.lib.scs" section=tt_ll_ncap18
include "/adl/design_kits/UMC/umc-65/UMK65FDKLLC00000OA_B11_DESIGNKIT/umc65ll/../Models/Spectre/l65ll_v181.lib.scs" section=tt_ll_ncap25
include "/adl/design_kits/UMC/umc-65/UMK65FDKLLC00000OA_B11_DESIGNKIT/umc65ll/../Models/Spectre/l65ll_v181.lib.scs" section=tt_ll_ncap33
include "/adl/design_kits/UMC/umc-65/UMK65FDKLLC00000OA_B11_DESIGNKIT/umc65ll/../Models/Spectre/l65ll_v181.lib.scs" section=tt_ll_pcap12
include "/adl/design_kits/UMC/umc-65/UMK65FDKLLC00000OA_B11_DESIGNKIT/umc65ll/../Models/Spectre/l65ll_v181.lib.scs" section=tt_ll_pcap18
include "/adl/design_kits/UMC/umc-65/UMK65FDKLLC00000OA_B11_DESIGNKIT/umc65ll/../Models/Spectre/l65ll_v181.lib.scs" section=tt_ll_pcap25
include "/adl/design_kits/UMC/umc-65/UMK65FDKLLC00000OA_B11_DESIGNKIT/umc65ll/../Models/Spectre/l65ll_v181.lib.scs" section=tt_ll_pcap33
include "/adl/design_kits/UMC/umc-65/UMK65FDKLLC00000OA_B11_DESIGNKIT/umc65ll/../Models/Spectre/l65ll_v181.lib.scs" section=tt_ll_res
include "/adl/design_kits/UMC/umc-65/UMK65FDKLLC00000OA_B11_DESIGNKIT/umc65ll/../Models/Spectre/L65LL_RVT12_V101_RF.lib.scs" section=tt
include "/adl/design_kits/UMC/umc-65/UMK65FDKLLC00000OA_B11_DESIGNKIT/umc65ll/../Models/Spectre/L65LL_HVT12_V101_RF.lib.scs" section=tt
include "/adl/design_kits/UMC/umc-65/UMK65FDKLLC00000OA_B11_DESIGNKIT/umc65ll/../Models/Spectre/L65LL_LVT12_V101_RF.lib.scs" section=tt
include "/adl/design_kits/UMC/umc-65/UMK65FDKLLC00000OA_B11_DESIGNKIT/umc65ll/../Models/Spectre/L65LL_IO18_V101_RF.lib.scs" section=tt
include "/adl/design_kits/UMC/umc-65/UMK65FDKLLC00000OA_B11_DESIGNKIT/umc65ll/../Models/Spectre/L65LL_IO25_V101_RF.lib.scs" section=tt
include "/adl/design_kits/UMC/umc-65/UMK65FDKLLC00000OA_B11_DESIGNKIT/umc65ll/../Models/Spectre/L65LL_IO33_V111_RF.lib.scs" section=tt
include "/adl/design_kits/UMC/umc-65/UMK65FDKLLC00000OA_B11_DESIGNKIT/umc65ll/../Models/Spectre/L65LL_VARMIS12_V111_RF.lib.scs" section=typ
include "/adl/design_kits/UMC/umc-65/UMK65FDKLLC00000OA_B11_DESIGNKIT/umc65ll/../Models/Spectre/L65LL_VARMIS18_V111_RF.lib.scs" section=typ
include "/adl/design_kits/UMC/umc-65/UMK65FDKLLC00000OA_B11_DESIGNKIT/umc65ll/../Models/Spectre/L65LL_VARMIS25_V121_RF.lib.scs" section=typ
include "/adl/design_kits/UMC/umc-65/UMK65FDKLLC00000OA_B11_DESIGNKIT/umc65ll/../Models/Spectre/L65LL_VARMIS33_V111_RF.lib.scs" section=typ
include "/adl/design_kits/UMC/umc-65/UMK65FDKLLC00000OA_B11_DESIGNKIT/umc65ll/../Models/Spectre/L65LL_VARDIOP_V101_RF.lib.scs" section=typ
include "/adl/design_kits/UMC/umc-65/UMK65FDKLLC00000OA_B11_DESIGNKIT/umc65ll/../Models/Spectre/momcaps_array_vp3_rfvcl_V101.lib.scs" section=typ
include "/adl/design_kits/UMC/umc-65/UMK65FDKLLC00000OA_B11_DESIGNKIT/umc65ll/../Models/Spectre/momcaps_array_vp4_rfvcl_V101.lib.scs" section=typ
include "/adl/design_kits/UMC/umc-65/UMK65FDKLLC00000OA_B11_DESIGNKIT/umc65ll/../Models/Spectre/momcaps_array_vp5_rfvcl_V101.lib.scs" section=typ
include "/adl/design_kits/UMC/umc-65/UMK65FDKLLC00000OA_B11_DESIGNKIT/umc65ll/../Models/Spectre/L65_MIMCAPS_20F_KF_V101_RF.lib.scs" section=tt
include "/adl/design_kits/UMC/umc-65/UMK65FDKLLC00000OA_B11_DESIGNKIT/umc65ll/../Models/Spectre/L65LL_RNPPO_V101_RF.lib.scs" section=typ
include "/adl/design_kits/UMC/umc-65/UMK65FDKLLC00000OA_B11_DESIGNKIT/umc65ll/../Models/Spectre/L65LL_RNNPO_V101_RF.lib.scs" section=typ
include "/adl/design_kits/UMC/umc-65/UMK65FDKLLC00000OA_B11_DESIGNKIT/umc65ll/../Models/Spectre/L65LL_RNHR_V101_RF.lib.scs" section=typ
include "/adl/design_kits/UMC/umc-65/UMK65FDKLLC00000OA_B11_DESIGNKIT/umc65ll/../Models/Spectre/L65_pad_rf_V101.lib.scs" section=typ

include "adc_analog.sp"

amsd {
    portmap subckt=adc_analog reffile="./adc_analog_spice.sv" porttype=name refformat=sv autobus=yes
    config cell=adc_analog use=spice
    ie vsup=1.2
}

// Sim setup
saveNodes options rawfmt=sst2 save=all
dcDom dc dc_pivot_check=yes
timeDom tran stop=1m errpreset=liberal  dc_pivot_check=yes

simulatorOptions options psfversion="1.4.0" reltol=1e-3 vabstol=1e-6 \
    iabstol=1e-12 temp=27 tnom=27 scalem=1.0 scale=1.0 gmin=1e-12 rforce=1 \
    maxnotes=5 maxwarns=5 digits=5 cols=80 pivrel=1e-3 \
    sensfile="../psf/sens.output" checklimitdest=psf
modelParameter info what=models where=rawfile
element info what=inst where=rawfile
outputParameter info what=output where=rawfile
designParamVals info what=parameters where=rawfile
primitives info what=primitives where=rawfile
subckts info what=subckts where=rawfile
saveOptions options save=allpub
