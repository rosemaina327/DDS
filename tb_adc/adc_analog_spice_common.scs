// This file is includes from SS/TT main file which provides the simulation models
simulator lang=spectre

// Include Analog component Scehmatic
include "adc_analog.sp"

amsd {
    portmap subckt=adc_analog reffile="./adc_analog_spice.sv" porttype=name refformat=sv autobus=yes
    config cell=adc_analog use=spice
    ie vsup=1.2
}

// Sim setup
saveNodes options rawfmt=sst2 save=all
dcDom dc dc_pivot_check=yes
timeDom tran stop=1m errpreset=liberal  dc_pivot_check=yes

simulatorOptions options psfversion="1.4.0" reltol=1e-3 vabstol=1e-6 \
    iabstol=1e-12 temp=27 tnom=27 scalem=1.0 scale=1.0 gmin=1e-12 rforce=1 \
    maxnotes=5 maxwarns=5 digits=5 cols=80 pivrel=1e-3 \
    sensfile="../psf/sens.output" checklimitdest=psf
modelParameter info what=models where=rawfile
element info what=inst where=rawfile
outputParameter info what=output where=rawfile
designParamVals info what=parameters where=rawfile
primitives info what=primitives where=rawfile
subckts info what=subckts where=rawfile
saveOptions options save=allpub
